* Switched Capacitor OTA Open-Loop AC Analysis
.lib ../../device_models/sky130_fd_pr/combined_models/sky130.lib.spice tt
.global VDD GND
.temp 27.0

* Design variables injected by my_testbench_template/src/ngspice.py
.include 'design_var.inc'
.param
+L_op={L_op_base*1}
+L_sw={L_sw_base*1}
+W_op1={W_op1_base*1}
+W_op2={W_op2_base*1}
+W_sw={W_sw_base*1}

*********** Unit Under Test ********************
.include "ac_switched_capacitor.cir"
*********** Test-bench *************************
XOTA VINP VINN VOUT VDD GND SWITCHED_CAPACITOR_OTA
VINP VINP GND DC 0.9 AC 0.5
VINN VINN GND DC 0.9 AC -0.5
VDD VDD GND DC 1.8

.control
set noaskquit
set wr_singlescale
set wr_vecnames

op
ac dec 50 1 1G

let gain_mag = db(v(VOUT))
let gain_phase = phase(v(VOUT)) * 180 / pi
let freq_vec = frequency

let dc_gain_db = gain_mag[0]

let i = 0
while i < length(gain_mag) - 1
  if gain_mag[i] >= 0 & gain_mag[i+1] < 0
    let ugbw_hz = freq_vec[i]
    let phase_ugf = gain_phase[i]
    if phase_ugf >= 0 & phase_ugf <= 90
      let phase_margin_deg = phase_ugf
    else
      if phase_ugf > 180
        let phase_ugf = phase_ugf - 360
      end
      let phase_margin_deg = 180 + phase_ugf
    end
    break
  end
  let i = i + 1
end

let ugbw_mhz = real(ugbw_hz) / 1e6
let phase_margin_deg = real(phase_margin_deg)
print dc_gain_db phase_margin_deg ugbw_mhz

quit
.endc
.end
