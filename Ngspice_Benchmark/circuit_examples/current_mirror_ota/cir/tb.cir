* OTA testbench
  .lib ../../device_models/sky130_fd_pr/combined_models/sky130.lib.spice tt

* Design variables injected by my_testbench_template/src/ngspice.py
.include 'design_var.inc'
.param
+W_casc={W_casc_base*16}
+W_diff={W_diff_base*8}
+W_mirror={W_mirror_base*6}
+W_out={W_mirror_base*12}
+W_tail={W_tail_base*4}

*********** Unit Under Test ********************
.include "current_mirror_ota.cir"
*********** Test-bench *************************

  VDD VDD 0 DC 1.8
  VSS VSS 0 DC 0
  IBIAS VDD ID DC 20e-6
  VINP VINP 0 DC 0.9 AC 0.5
  VINN VINN 0 DC 0.9 AC -0.5
  XOTA VSS VDD VOUT VINN VINP ID CURRENT_MIRROR_OTA
  CLOAD VOUT 0 1e-12

  .op

  .control
  op
  let vdd_current = abs(i(VDD))
  let power_dc = vdd_current * 1.8
  print power_dc

  ac dec 100 1 10g
  let vout_ac = v(VOUT)
  let gain_db = db(vout_ac)
  let dc_gain_db = gain_db[0]
  print dc_gain_db

  meas ac ugbw WHEN gain_db=0 CROSS=1

  * my_testbench_template parse-friendly post-processed measures
  let power_dc = op1.power_dc * 1e6
  let ugbw = ugbw * 1e-6
  let fom = dc_gain_db * ugbw / power_dc
  print power_dc ugbw fom

  quit
  .endc

  .end
