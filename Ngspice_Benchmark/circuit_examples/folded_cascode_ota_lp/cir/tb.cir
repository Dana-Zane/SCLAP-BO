* Folded-Cascode OTA with Sallen-Key LPF
.lib ../../device_models/sky130_fd_pr/combined_models/sky130.lib.spice tt
.options GMIN=1e-10 RELTOL=1e-4 ABSTOL=1e-12

* Design variables injected by my_testbench_template/src/ngspice.py
.include 'design_var.inc'
.param
+W_casc_n={W_casc_n_base*20}
+W_casc_p={W_casc_p_base*20}
+W_fold={W_fold_base*4}
+W_in={W_in_base*4}
+W_mirr={W_mirr_base*20}
+W_sink={W_sink_base*20}

*********** Unit Under Test ********************
.include "folded_cascode_ota_lp.cir"
*********** Test-bench *************************

* Power supplies
VVDD  VDD_NODE   0   DC 1.8
VVSS  VSS_NODE   0   DC 0

* Bias voltages
VBN   VBN_NODE   0   DC 0.7
VBP   VBP_NODE   0   DC 1.0

* Differential inputs
VINP  VINP_NODE  0   DC 0.9 AC 0.5
VINN  VINN_NODE  0   DC 0.9 AC -0.5

* Tail current
VTAIL VDD_NODE VTAIL_NODE DC 0
ITAIL_SRC VTAIL_NODE 0 DC 1e-05

* DUT
XOTA  VSS_NODE VDD_NODE VFINAL_OUT_NODE VINN_NODE VINP_NODE VBN_NODE VBP_NODE VTAIL_NODE FOLDED_CASCODE_OTA
CLOAD VFINAL_OUT_NODE VSS_NODE 1e-12

.op
.ac dec 200 1 1G

.measure ac dc_gain_db max vdb(VFINAL_OUT_NODE)
.measure ac ugbw when vdb(VFINAL_OUT_NODE)=0 fall=1

.control
set noaskquit
op
ac dec 200 1 1G

* Power - use scalar value
let pwr = abs(i(VVDD)[0]) * 1.8
echo "POWER_VALUE"
print pwr

* Frequency response
let vout_ac = ac1.v(VFINAL_OUT_NODE)
let gain_db_vec = 20*log10(mag(vout_ac))
let phase_vec = 180/pi*cph(vout_ac)
let freq_vec = frequency

let gain_dc = gain_db_vec[0]
echo "GAIN_VALUE"
print gain_dc

* Find -3dB cutoff
let target = gain_dc - 3
let idx = 0
while idx < length(gain_db_vec) - 1
  if (gain_db_vec[idx] >= target) & (gain_db_vec[idx+1] < target)
    let fc_3db = freq_vec[idx]
    break
  end
  let idx = idx + 1
end
echo "CUTOFF_VALUE"
print fc_3db

* Find UGBW
let idx = 0
while idx < length(gain_db_vec) - 1
  if (gain_db_vec[idx] > 0) & (gain_db_vec[idx+1] <= 0)
    let ugbw_hz = freq_vec[idx]
    break
  end
  let idx = idx + 1
end
echo "UGBW_VALUE"
print ugbw_hz

* Stopband attenuation
let fc_10x = fc_3db * 10
let gain_10x = -100
let idx = 0
while idx < length(freq_vec) - 1
  if (freq_vec[idx] <= fc_10x) & (freq_vec[idx+1] > fc_10x)
    let gain_10x = gain_db_vec[idx]
    break
  end
  let idx = idx + 1
end
let stopband_att = gain_dc - gain_10x
echo "STOPBAND_VALUE"
print stopband_att

* Roll-off (between fc and 10*fc)
let rolloff = (gain_db_vec[idx-1] - gain_10x) / log10(fc_10x / fc_3db)
echo "ROLLOFF_VALUE"
print rolloff

* Phase margin
let idx = 0
while idx < length(freq_vec) - 1
  if (freq_vec[idx] <= ugbw_hz) & (freq_vec[idx+1] > ugbw_hz)
    let pm = 180 + phase_vec[idx]
    break
  end
  let idx = idx + 1
end
echo "PHASE_VALUE"
print pm

let lpf_cutoff_hz = real(fc_3db) * 1e-6
let lpf_passband_gain_db = real(gain_dc)
let lpf_stopband_atten_db = real(stopband_att)
print lpf_cutoff_hz lpf_passband_gain_db lpf_stopband_atten_db

* Save data
wrdata lpf_ac_response.txt frequency gain_db_vec phase_vec

quit
.endc
.end
